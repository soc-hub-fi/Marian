# RV_PLIC register template
#
# Parameter (given by python tool)
#  - src:    Number of Interrupt Sources
#  - target: Number of Targets that handle interrupt requests
#  - prio:   Max value of interrupt priorities
{
  name: "RV_PLIC",
  clock_primary: "clk_fixed",
  bus_device: "tlul",
  regwidth: "32",
  registers: [
    { multireg: {
        name: "IP",
        desc: "Interrupt Pending",
        count: 6,
        cname: "RV_PLIC",
        swaccess: "ro",
        hwaccess: "hwo",
        fields: [
          { bits: "0", name: "P", desc: "Interrupt Pending of Source" }
        ],
      }
    },
    { multireg: {
        name: "LE",
        desc: "Interrupt Source mode. 0: Level, 1: Edge-triggered",
        count: 6,
        cname: "RV_PLIC",
        swaccess: "rw",
        hwaccess: "hro",
        fields: [
          { bits: "0", name: "LE", desc: "L0E1" }
        ],
      }
    },
    { name: "PRIO0",
      desc: "Interrupt Source 0 Priority",
      swaccess: "rw",
      hwaccess: "hro",
      fields: [
        { bits: "2:0" }
      ],
    }
    { name: "PRIO1",
      desc: "Interrupt Source 1 Priority",
      swaccess: "rw",
      hwaccess: "hro",
      fields: [
        { bits: "2:0" }
      ],
    }
    { name: "PRIO2",
      desc: "Interrupt Source 2 Priority",
      swaccess: "rw",
      hwaccess: "hro",
      fields: [
        { bits: "2:0" }
      ],
    }
    { name: "PRIO3",
      desc: "Interrupt Source 3 Priority",
      swaccess: "rw",
      hwaccess: "hro",
      fields: [
        { bits: "2:0" }
      ],
    }
    { name: "PRIO4",
      desc: "Interrupt Source 4 Priority",
      swaccess: "rw",
      hwaccess: "hro",
      fields: [
        { bits: "2:0" }
      ],
    }
    { name: "PRIO5",
      desc: "Interrupt Source 5 Priority",
      swaccess: "rw",
      hwaccess: "hro",
      fields: [
        { bits: "2:0" }
      ],
    }
    { multireg: {
        name: "IE0",
        desc: "Interrupt Enable for Target 0",
        count: 6,
        cname: "RV_PLIC",
        swaccess: "rw",
        hwaccess: "hro",
        fields: [
          { bits: "0", name: "E", desc: "Interrupt Enable of Source" }
        ],
      }
    }
    { multireg: {
        name: "IE1",
        desc: "Interrupt Enable for Target 1",
        count: 6,
        cname: "RV_PLIC",
        swaccess: "rw",
        hwaccess: "hro",
        fields: [
          { bits: "0", name: "E", desc: "Interrupt Enable of Source" }
        ],
      }
    }
    { name: "THRESHOLD0",
      desc: "Threshold of priority for Target 0",
      swaccess: "rw",
      hwaccess: "hro",
      fields: [
        { bits: "2:0" }
      ],
    }
    { name: "THRESHOLD1",
      desc: "Threshold of priority for Target 1",
      swaccess: "rw",
      hwaccess: "hro",
      fields: [
        { bits: "2:0" }
      ],
    }
    { name: "CC0",
      desc: "Claim by read, complete by write for Target 0",
      swaccess: "rw",
      hwaccess: "hrw",
      hwext: "true",
      hwqe: "true",
      hwre: "true",
      fields: [
        { bits: "2:0" }
      ],
    }
    { name: "CC1",
      desc: "Claim by read, complete by write for Target 1",
      swaccess: "rw",
      hwaccess: "hrw",
      hwext: "true",
      hwqe: "true",
      hwre: "true",
      fields: [
        { bits: "2:0" }
      ],
    }
  ],
}

